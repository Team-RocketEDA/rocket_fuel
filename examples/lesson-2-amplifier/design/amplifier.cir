* A common-source amplifier on generic 1.8 V level-1 models (for learning, not a foundry PDK).
* Change RL below, then press Run checks.
.param RL=5k
.model nch nmos level=1 vto=0.45 kp=250u lambda=0.05
.subckt amplifier in out vdd vss
M1 out in vss vss nch W=10u L=1u
RL vdd out {RL}
.ends amplifier
